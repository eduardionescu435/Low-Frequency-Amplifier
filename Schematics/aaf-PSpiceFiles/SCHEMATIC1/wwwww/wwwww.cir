** Profile: "SCHEMATIC1-wwwww"  [ C:\Users\Eduard\Desktop\New folder (2)\Schematics\aaf-pspicefiles\schematic1\wwwww.sim ]

** Creating circuit file "wwwww.cir"
** WARNING: THIS AUTOMATICALLY GENERATED FILE MAY BE OVERWRITTEN BY SUBSEQUENT SIMULATIONS

*Libraries:
* Profile Libraries :
* Local Libraries :
.LIB "C:/Users/Eduard/Desktop/New folder (2)/biblioteci spice/bc807-25.lib"
.LIB "C:/Users/Eduard/Desktop/New folder (2)/biblioteci spice/bc817-25.lib"
.LIB "C:/Users/Eduard/Desktop/New folder (2)/biblioteci spice/bc846b.lib"
.LIB "C:/Users/Eduard/Desktop/New folder (2)/biblioteci spice/bc856b.lib"
.LIB "C:/Users/Eduard/Desktop/New folder (2)/biblioteci spice/opto.lib"
* From [PSPICE NETLIST] section of C:\Users\Eduard\AppData\Roaming\SPB_Data\cdssetup\OrCAD_PSpice\17.2.0\PSpice.ini file:
.lib "nomd.lib"

*Analysis directives:
.TRAN  0 100ms 0 5u SKIPBP
.OPTIONS ADVCONV
.PROBE64 V(alias(*)) I(alias(*)) W(alias(*)) D(alias(*)) NOISE(alias(*))
.INC "..\SCHEMATIC1.net"

.END
